ADE simulation setup
Run mode: Single Run, Sweeps and Corners
Tests:
  DAC@:try:1: DAC@/try/schematic, simulator spectre
Global variables:
  l = 500n
  vds = 0.15
  vgs = 490m
  w = 20u

ADE simulation setup
Run mode: Single Run, Sweeps and Corners
Tests:
  DAC@:CM_TB:1: DAC@/CM_TB/schematic, simulator spectre
Global variables:
  w = 2u
  l = 700n

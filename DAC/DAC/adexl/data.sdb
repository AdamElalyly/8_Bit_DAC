ADE simulation setup
Run mode: Single Run, Sweeps and Corners
Tests:
  DAC:DAC:1: DAC/DAC/schematic, simulator spectre
    Outputs: 1. Average LSB Step (V_lsb); 2. DNL Waveform (in LSBs); 3. INL Waveform (in LSBs); ymax(abs((((sample(VT("/IOUT_P") 1.5e-06 0.0002555 "linear" 1e-06) - delay(sample(VT("/IOUT_P") 5e-07 0.0002555 "linear" 1e-06) 1e-06)) / ((value(sample(VT("/IOUT_P") 5e-07 0.0002555 "linear" 1e-06) 0.0002555) - value(sample(VT("/IOUT_P") 5e-07 0.0002555 "linear" 1e-06) 5e-07)) / 255.0)) - 1.0))); Max DNL (in LSBs):; Max INL (in LSBs):; Differential Output; Differential output
Global variables:
  BINARY_0 = 1
  BINARY_1 = 2
  BINARY_2 = 4
  BINARY_3 = 8
  BINARY_4 = 16
  multiplayers_UNARY = 32
  vbias = 170m

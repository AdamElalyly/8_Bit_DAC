ADE simulation setup
Run mode: Single Run, Sweeps and Corners
Tests:
  DAC:CM_TB:1: DAC/CM_TB/schematic, simulator spectre
Global variables:
  vbias = 100m
  VDC = 800m

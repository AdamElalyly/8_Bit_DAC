ADE simulation setup
Run mode: Monte Carlo Sampling
Tests:
  DAC@:DAC:1: DAC@/DAC/schematic, simulator spectre
Global variables:
  BINARY_0 = 1
  BINARY_1 = 2
  BINARY_2 = 4
  BINARY_3 = 8
  BINARY_4 = 16
  multiplayers_UNARY = 32
  vbias = 0.07
  K = 1
Monte Carlo Sampling options: mcmethod=mismatch, mcnumpoints=200

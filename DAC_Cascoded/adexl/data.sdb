ADE simulation setup
Run mode: Single Run, Sweeps and Corners
Tests:
  DAC:DAC_Cascoded:1: DAC/DAC_Cascoded/schematic, simulator spectre
    Outputs: 1. Average LSB Step (V_lsb)
Global variables:
  BINARY_0 = 1
  BINARY_1 = 2
  BINARY_2 = 4
  BINARY_3 = 8
  BINARY_4 = 16
  multiplayers_UNARY = 32
